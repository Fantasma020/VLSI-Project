* File: inv.pex.sp
* Created: Tue Mar 10 12:05:34 2026
* Program "Calibre xRC"
* Version "v2024.4_12.9"
*
.include "inv.pex.sp.pex"
.subckt inv  GND! OUT VDD! IN
*
* IN	IN
* VDD!	VDD!
* OUT	OUT
* GND!	GND!
XD0_noxref N_GND!_D0_noxref_pos N_VDD!_D0_noxref_neg DIODENWX  AREA=4.16047e-12
+ PERIM=9.456e-06
XMMN0 N_OUT_MMN0_d N_IN_MMN0_g N_GND!_MMN0_s N_GND!_D0_noxref_pos NFET L=6.6e-08
+ W=1.4e-06 AD=3.948e-13 AS=3.962e-13 PD=3.364e-06 PS=3.366e-06 NRD=0.0978571
+ NRS=0.0914286 M=1 NF=1 CNR_SWITCH=0 PCCRIT=0 PAR=1 PTWELL=0 SA=2.83e-07
+ SB=2.82e-07 SD=0 PANW1=0 PANW2=0 PANW3=0 PANW4=0 PANW5=0 PANW6=9.9e-16
+ PANW7=1.32e-14 PANW8=1.32e-14 PANW9=2.64e-14 PANW10=3.861e-14
XMMP0 N_OUT_MMP0_d N_IN_MMP0_g N_VDD!_MMP0_s N_VDD!_D0_noxref_neg PFET L=6.6e-08
+ W=1.7e-06 AD=5.049e-13 AS=5.78e-13 PD=3.994e-06 PS=4.08e-06 NRD=0.0805882
+ NRS=0.0747059 M=1 NF=1 CNR_SWITCH=0 PCCRIT=0 PAR=1 PTWELL=1 SA=3.4e-07
+ SB=2.97e-07 SD=0 PANW1=0 PANW2=0 PANW3=0 PANW4=0 PANW5=0 PANW6=1.649e-13
+ PANW7=6.1744e-14 PANW8=1.32e-14 PANW9=4.6662e-14 PANW10=7.92e-14
*
.include "inv.pex.sp.INV.pxi"
*
.ends
*
*
